addrmap dac_regs {

    desc = "DAC sine gen register map. Software-writable registers other than ENABLE are double-buffered and take effect when ENABLE is written.";
    default regwidth=16;
    default accesswidth=16;
    default sw=rw;
    default hw=r;
    default reset=0x0;
    default swmod=true;

    enum frequency_mode_e {
        DC = 0;
        AC = 1;
    };

    reg {
        desc = "Double-buffered amplitude configuration. Writes take effect when ENABLE is written.";
        buffer_writes = true;
        field {
            desc = "Linear amplitude divider. The output is about a/15 of full scale.";
            reset=8;
        } amplitude_div_linear [3:0];
        field {
            desc = "Logarithmic amplitude divider. The output is divided by 2^(15-b).";
            reset=0xF;
        } amplitude_div_log [7:4];
        // bits [15:8] reserved
    } AC_CONFIG;

    reg dc_value_reg {
        desc = "Double-buffered DC output value. Writes take effect when ENABLE is written.";
        buffer_writes = true;
        field {
            desc = "DAC output value in DC mode.";
        } dc_value [7:0];
        // bits [15:8] reserved
    };

    dc_value_reg DACP_DC_VALUE;
    dc_value_reg DACN_DC_VALUE;

    reg {
        desc = "Double-buffered clock divider. Writes take effect when ENABLE is written.";
        buffer_writes = true;
        field {
            desc = "Global DAC clock divider value. Describes a power of 2; 0 means no clock division from system clock, F means 1 << 16 division from system clock.";
        } clk_div_value [7:0];
        // bits [15:8] reserved
    } CLK_DIV;

    reg {
        desc = "Double-buffered pulldown controls. dacp_power and dacn_power take effect when ENABLE is written. dsm_locked is hardware-written and is not buffered.";
        buffer_writes = true;
        field {
            desc="DACP pulldown strength when disabled. 0: 1 kOhm, 1: 100 kOhm";
        } dacp_power [0:0];
        field {
            desc="DACN pulldown strength when disabled. 0: 1 kOhm, 1: 100 kOhm";
        } dacn_power [1:1];
        field {
            desc="If 1, means delta-sigma modulator is warmed up after enable. Hardware-written and not double-buffered.";
            sw=r;
            hw=w;
        } dsm_locked [4:4];
        // bits [15:5] reserved
    } STATUS;

    reg {
        desc = "Double-buffered frequency tuning word. Writes take effect when ENABLE is written.";
        buffer_writes = true;
        field {
            desc = "DDS frequency tuning word (FTW). The output frequency is f_out = FTW * fs / 2^16.";
        } frequency [15:0];
    } FREQUENCY;

    reg {
        desc = "DAC enables and modes. Not double-buffered. A write commits the other DAC registers.";
        field {
            desc = "Enable for DACP.";
        } dacp_enable [0:0];
        field {
            desc = "Mode for DACP.";
            encode = frequency_mode_e;
            reset = frequency_mode_e::DC;
        } dacp_mode [1:1];
        field {
            desc = "Enable for DACN.";
        } dacn_enable [2:2];
        field {
            desc = "Mode for DACN.";
            encode = frequency_mode_e;
            reset = frequency_mode_e::DC;
        } dacn_mode [3:3];
        field {
            desc = "Enable for DAC delta-sigma modulator. Used to reduce quantization noise in AC mode.";
        } dsm_enable [4:4];
        // bits [15:5] reserved
    } ENABLE;

    // A write to ENABLE commits the buffered registers.
    AC_CONFIG->wbuffer_trigger = ENABLE;
    DACP_DC_VALUE->wbuffer_trigger = ENABLE;
    DACN_DC_VALUE->wbuffer_trigger = ENABLE;
    CLK_DIV->wbuffer_trigger = ENABLE;
    STATUS->wbuffer_trigger = ENABLE;
    FREQUENCY->wbuffer_trigger = ENABLE;
};
